//EEHEMT14 implementation in Verilog A by Samuel Mertens - Agilent

`include "disciplines.vams"
`include "constants.vams"

`define max_arg 40

module eehemt114_va (g, d, s);

    // %%DEVICE_CLASS=FET(NFET)%%

    parameter real UGW_N = 1               ;
    parameter real NGF_N = 1               ;
    parameter real Temp_N = 25             ;
    parameter real on_off = 0              ;
    parameter real UGW = 25                ;
    parameter real NOF = 2                 ;
    parameter real Rgtc = 0                ;
    parameter real Rdtc = 0                ;
    parameter real Rstc = 0                ;
    parameter real Rg = 23.07763961        ;
    parameter real Ris = 0.3               ;
    parameter real Rid = 0.001             ;
    parameter real Rs = 2                  ;
    parameter real Rd = 1                  ;
    parameter real Rdb = 5.00E+07          ;
    parameter real Cbs = 1.00E-15          ;
    parameter real Cdso = 1.20298E-14      ;
    parameter real Ugw = 75                ;
    parameter real Ngf = 2                 ;
    parameter real Tnom = 25               ;
    parameter real Vsat = 0.57             ;
    parameter real Vto = 0.258163647       ;
    parameter real Vtso = 0.358207805      ;
    parameter real Vtotc = 0               ;
    parameter real Vch = 1.4               ;
    parameter real Vdso = 3.5              ;
    parameter real Gamma = 0.0095          ;
    parameter real Gammatc = 0             ;
    parameter real Vgo = 0.618318978       ;
    parameter real Gmmax = 0.168291525     ;
    parameter real Gmmaxtc = 0             ;
    parameter real Kapa = 0.069042509      ;
    parameter real Vco = 0.75              ;
    parameter real Mu = 7.86E-06           ;
    parameter real Vbc = 0.95              ;
    parameter real Vba = 4.8               ;
    parameter real Deltgm = 0.4            ;  // 0.252 -> 0.4
    parameter real Alpha = 0.05            ;  // 0.01 -> 0.05
    parameter real Peff = 1.531985111      ;
    parameter real Tau_lag = 1.50E-12      ;
    parameter real Vtoac = 0.206665003     ;
    parameter real Vtoactc = 0             ;
    parameter real Gammaac = 0.0126        ;
    parameter real Gammaactc = 0           ;
    parameter real Vgoac = 0.625           ;
    parameter real Vtsoac = 0.3429         ;
    parameter real Gmmaxac = 0.138506784   ;
    parameter real Gmmaxactc = 0           ;
    parameter real Vcoac = 0.63            ;
    parameter real Deltgmac = 0.32         ;
    parameter real Kapaac = 0.045          ;
    parameter real Peffac = 10             ;
    parameter real Kdb = 50                ;
    parameter real Vdsm = 1                ;
    parameter real Gdbm = 1.00E-05         ;
    parameter real Is = 5.71752E-13        ;
    parameter real Xti = 3                 ;
    parameter real N = 1.697394727         ;
    parameter real Is2 = 5.00E-14          ;
    parameter real N2 = 0.034              ;
    parameter real Kbk = 2.64004E-14       ;
    parameter real Vbr = 0                 ;
    parameter real Idsoc = 0.393           ;
    parameter real Nbr = 8.6               ;
    parameter real rev1 = 0.03             ;
    parameter real rev2 = 1.10E-07         ;
    parameter real Xb1 = 0                 ;
    parameter real Deltds = 0.693          ;
    parameter real Deltgs = 0.378          ;
    parameter real Vinfl = 0.398           ;
    parameter real Vinfltc = 0             ;
    parameter real C11o = 3.47E-13         ;
    parameter real C11th = 7.00E-14        ;
    parameter real C12sat = 3.97235E-14    ;
    parameter real Cgdsat = 4.51166E-14    ;
    parameter real Lambda = 0.12           ;
    parameter real Nvg1 = 6.50E-07         ;
    parameter real Nvg2 = 9.6              ;
    parameter real Nvd1 = 75.5             ;
    parameter real Nvd2 = 183.6            ;
    parameter real UGW_nor = 0             ;
    //parameter real Lg = 3.76492E-11        ;
    //parameter real Ld = 6.8818E-12         ;
    //parameter real Ls = 2.77E-12           ;
    //parameter real Cgp = 2.03384E-14       ;
    //parameter real Cdp = 1.20E-14          ;

    inout d, g, s;
    electrical d, g, s, di, gi, si, dii, sii, ds, dsi;
    branch (gi, si) br_gisi;
    branch (di, si) br_disi;

    (*retrieve*) real Vds2,Vgs2,Vds,Vgs,Vgs1,Vts,Vt,Vg,Vx;
    (*retrieve*) real Igs,Igd,Ids;
    (*retrieve*) real WJcheck;
    (*retrieve*) real Deltgm_N,I_ds,Vc,Vb,Va,Idsv_All, tempsqrt,Idsvtemp,gmoff,a,b;

    real Rg_N,Temp_NK,Tnom_K,sfg,sf,Ris_N,Rid_N,Rs_N,Rd_N,Rdb_N;
    real Cdso_N,Cbs_N,Vto_N,Gamma_N,Vtso_N,Gmmax_N,Peff_N;
    //real Cdso_N,Cbs_N,Vto_N,Gamma_N,Vtso_N,Gmmax_N,Deltgm_N,Peff_N;
    real Vtoac_N,Gammaac_N,Vtsoac_N,Gmmaxac_N,Deltgmac_N,Peffac_N;
    real Kdb_N,Gdbm_N,Kbk_N,Idsoc_N,C11o_N,C11th_N,C12sat_N,Cgdsat_N,Vinfl_N;
    real Bandwidth,BW;
    real Idso1,arg,Idso,gmo1;
    real svb,Pdiss;
    //real I_ds,Vc,Vb,Va,Idsv_All,Idsvtemp,gmoff,a,b,svb,Pdiss;
    real Vgs_ac,Vts_ac,Vt_ac,Vg_ac,Vx_ac,Idso_ac1,gmo_ac1,arg_ac,Idso_ac;
    real Vcac,Vbac,Vaac,gmoff_ac,a_ac,b_ac,svb_ac,Idsv_All_ac;
    real I_ds_ac,Pdiss_ac,Ids_ac,Idbp,Idb;
    real Is_N,Is_N2,Idsdelay=0,Idbdelay=0;
    real f1,f2,Vj,Vo,Vgc,Vgy,gV,qg,qgc,qgy;
    real chargeconst,boltzmannconst;
    //real tempsqrt,RSCALE,Xb;
    real RSCALE,Xb;
    real pi;

    //Vc=Vco+Mu*(Vdso-Vds);
    //Vb=Vbc+Vc;
    //Vds＝br_disi

    analog function real  exp_soft;
        input x;
        real  x;
        begin
        if (x < `max_arg)
            exp_soft = exp(x);
            else
            exp_soft = (x + 1 - `max_arg) * exp(`max_arg);
        end
    endfunction
    analog begin
    chargeconst = 1.602192e-019;
    boltzmannconst= 1.380623e-023;
    RSCALE=1e6;
    Temp_NK=Temp_N+273.15;
    Tnom_K=Tnom+273.15;
    sf=UGW*NOF/(Ugw*Ngf);
    sfg=Ugw*NOF/(UGW*Ngf);
    Bandwidth=1.0;
    BW=Bandwidth*on_off;
    pi=3.14159265359;
    Rg_N=Rg*(1+Rgtc*(Temp_NK-Tnom_K))/sfg;
    Rd_N=Rd*(1+Rdtc*(Temp_NK-Tnom_K))/sf;
    Rs_N=Rs*(1+Rstc*(Temp_NK-Tnom_K))/sf;
    Ris_N=Ris/sf;
    Rid_N=Rid/sf;
    Rdb_N=Rdb/sf/RSCALE;
    Cdso_N=Cdso*sf;
    Cbs_N=Cbs*sf*RSCALE;
    Gamma_N=Gamma*pow((Temp_NK/Tnom_K),Gammatc);
    Vtso_N=Vtso+Vtotc*(Temp_NK-Tnom_K);
    Gmmax_N=(Gmmax+Gmmaxtc*(Temp_NK-Tnom_K))*sf;
    Deltgm_N=Deltgm*sf;
    Peff_N=Peff*sf;
    Vtoac_N=Vtoac+Vtoactc*(Temp_NK-Tnom_K);
    Gammaac_N=Gammaac*pow((Temp_NK/Tnom_K),Gammaactc);
    Vtsoac_N=Vtsoac+Vtoactc*(Temp_NK-Tnom_K);
    Gmmaxac_N=(Gmmaxac+Gmmaxactc*(Temp_NK-Tnom_K))*sf;
    Deltgmac_N=Deltgmac*sf;
    Peffac_N=Peffac*sf;
    Kdb_N=Kdb/sf;
    Gdbm_N=Gdbm*sf;
    Is_N=Is*sf*exp((Temp_NK/Tnom_K-1)*chargeconst*1.11/(boltzmannconst*N*(Temp_NK))+Xti/N*ln(Temp_NK/Tnom_K));
    Is_N2=Is2*sf*exp((Temp_NK/Tnom_K-1)*`P_Q*1.11/(boltzmannconst*N2*(Temp_NK))+Xti/N2*ln(Temp_NK/Tnom_K));
    Kbk_N=Kbk*sf;
    Idsoc_N=Idsoc*sf;
    Vinfl_N=Vinfl+Vinfltc*(Temp_NK-Tnom_K);
    C11o_N=C11o*sf;
    C11th_N=C11th*sf;
    C12sat_N=C12sat*sf;
    Cgdsat_N=Cgdsat*sf;

    Vto_N=Vto+Vtotc*(Temp_NK-Tnom_K);
    //230104 BY WJ;
    //Vds2=V(di,si);
    //Vgs2=V(gi,si);
    Vds2=V(br_disi);
    Vgs2=V(br_gisi);

    //$debug("Vds2,Vgs2 = %e %e",Vds2,Vgs2);
    if(Vds2>=0)
    begin
        Vds=Vds2;
        Vgs1=Vgs2;
    end else
    begin
        Vds=-Vds2;
        Vgs1=Vgs2-Vds2;
    end
    Vts=(Vtso_N-Vch)/(1+Gamma_N*(Vdso-Vds))+Vch;
    if(Vgs1<Vts && Vtso_N>Vto_N)
    begin
        Vgs=Vts;
    end else
    begin
        Vgs=Vgs1;
    end

    Vt=(Vto_N-Vch)/(1+Gamma_N*(Vdso-Vds))+Vch;
    Vg=(Vgo-Vch)/(1+Gamma_N*(Vdso-Vds))+Vch;
    Vx=(Vgs-Vch)*(1+Gamma_N*(Vdso-Vds));

    if (Vgs >= Vg)
    begin
        Idso1=Gmmax_N*(Vx-(Vgo+Vto_N)/2+Vch);
        gmo1=Gmmax_N*(1+Gamma_N*(Vdso-Vds));
    end	else
    begin
        if (Vgs <= Vt)
        begin
            Idso1=0.0;
            gmo1=0.0;
        end else
        begin
            Idso1=Gmmax_N/2*(((Vto_N-Vgo)/pi)*sin(pi*(Vx-(Vgo-Vch))/(Vto_N-Vgo))+Vx-(Vto_N-Vch));
            gmo1=Gmmax_N/2*(1+Gamma_N*(Vdso-Vds))*(cos(pi*(Vx-(Vgo-Vch))/(Vto_N-Vgo))+1);
        end
    end
    if (Idso1!=0 && Vgs1<Vts && Vtso_N>Vto_N)
    begin
        arg=-(gmo1/Idso1)*(Vts-Vgs1);//might be discontinuous if Idso1==0
    end else
    begin
        arg=0.0;
    end
    Idso=Idso1*exp(arg);

    Vc=Vco+Mu*(Vdso-Vds);
    Vb=Vbc+Vc;
    Va=Vb-Vba;
    if (Vco >= Vgo)
    begin
        gmoff=Gmmax_N;
    end else
    begin
        if (Vco <= Vto_N)
        begin
            gmoff=0.0;
        end else
        begin
            gmoff=0.5*Gmmax_N*(cos(pi*(Vco-Vgo)/(Vto_N-Vgo))+1);
        end
    end
    svb=Deltgm_N*Vbc/sqrt(Alpha*Alpha+Vbc*Vbc);
    b=svb*Vba/(Deltgm_N*(sqrt(Alpha*Alpha+(Vb-Vc)*(Vb-Vc))-Alpha)-gmoff);
    a=(Deltgm_N*(sqrt(Alpha*Alpha+(Vb-Vc)*(Vb-Vc))-Alpha)-gmoff)/(pow(Vba,b));
    //$debug("Vc,Vb,Va=%e %e %e",Vc,Vb,Va);
    //$debug("a,b,svb=%e %e %e",a,b,svb);
    if(Vgs > Vb)
    begin
        tempsqrt=sqrt(Alpha*Alpha+(Vb-Vc)*(Vb-Vc));
        Idsvtemp=Deltgm_N*(0.5*((Vb-Vc)*tempsqrt+Alpha*Alpha*ln(((Vb-Vc)+tempsqrt)/Alpha))-Alpha*(Vb-Vc));
        Idsv_All=a/(b+1)*((pow((Vgs-Va),(b+1.0))-pow(Vba,(b+1.0))))+gmoff*(Vgs-Vb)+Idsvtemp;
        //$debug("1 Idsv_All = %e %e %e",Idsv_All,(Vgs-Va),Vba);
        WJcheck = Idsv_All;

    end else
    begin
        if(Vgs <= Vc)
        begin
            Idsv_All=0.0;
            //$debug("3 Idsv_All");
        end
        else begin
            //Idsv_All=Deltgm_N*(0.5*((Vgs-Vc)*sqrt(Alpha*Alpha+(Vgs-Vc)*(Vgs-Vc))+Alpha*Alpha*ln(((Vgs-Vc)+sqrt(Alpha*Alpha+(Vgs-Vc)*(Vgs-Vc)))/Alpha))-Alpha*(Vgs-Vc));
            tempsqrt=sqrt(Alpha*Alpha+(Vgs-Vc)*(Vgs-Vc));
            Idsv_All=Deltgm_N*(0.5*((Vgs-Vc)*tempsqrt+Alpha*Alpha*ln(((Vgs-Vc)+tempsqrt)/Alpha))-Alpha*(Vgs-Vc));
            //$debug("2 Idsv_All = %e %e %e %e\n",Idsv_All,(Vgs-Vc),tempsqrt,Deltgm_N);
        end
    end

    I_ds=(Idso-Idsv_All)*(1+Kapa*Vds)*tanh(3*Vds/Vsat);

    $write("I_ds<0 for Vds=%e and Vgs=%e\n",V(d,s),V(g,s));

    if(I_ds<0)
    begin
        I_ds=0;
        $write("I_ds<0 for Vds=%e and Vgs=%e\n",V(d,s),V(g,s));
    end
    $debug("Idso,Idsv_All = %e %e",Idso,Idsv_All);
    Pdiss=I_ds*Vds;
    Ids=I_ds/(1+Pdiss/Peff_N);
    $debug("Ids,I_ds,Pdiss = %e %e %e",Ids,I_ds,Pdiss);
    Vts_ac=(Vtsoac_N-Vch)/(1+Gammaac_N*(Vdso-Vds))+Vch;
    if (Vgs1<Vts_ac && Vtsoac_N>Vtoac_N)
    begin
        Vgs_ac=Vts_ac;
    end else
    begin
        Vgs_ac=Vgs1;
    end
    //$debug("Vgs_ac,Vds,Vts_ac= %e %e %e",Vgs_ac,Vds,Vts_ac);
    Vt_ac=(Vtoac_N-Vch)/(1+Gammaac_N*(Vdso-Vds))+Vch;
    Vg_ac=(Vgoac-Vch)/(1+Gammaac_N*(Vdso-Vds))+Vch;
    Vx_ac=(Vgs_ac-Vch)*(1+Gammaac_N*(Vdso-Vds));

    if (Vgs_ac >= Vg_ac)
    begin
        Idso_ac1= Gmmaxac_N*(Vx_ac-(Vgoac+Vtoac_N)/2+Vch);
        gmo_ac1= Gmmaxac_N*(1+Gammaac_N*(Vdso-Vds));
    end else
    begin
        if (Vgs_ac <= Vt_ac)
        begin
            Idso_ac1= 0.0;
            gmo_ac1= 0.0;
        end else
        begin
            Idso_ac1= Gmmaxac_N/2*(((Vtoac_N-Vgoac)/pi)*sin(pi*(Vx_ac-(Vgoac-Vch))/(Vtoac_N-Vgoac))+Vx_ac-(Vtoac_N-Vch));
            gmo_ac1= Gmmaxac_N/2*(1+Gammaac_N*(Vdso-Vds))*(cos(pi*(Vx_ac-(Vgoac-Vch))/(Vtoac_N-Vgoac))+1);
        end
    end
    if (Idso_ac1!=0 && Vgs1<Vts_ac && Vtsoac_N>Vtoac_N)
    begin
        arg_ac=-(gmo_ac1/Idso_ac1)*(Vts_ac-Vgs1);
    end else
    begin
    	arg_ac=0;
    end
    Idso_ac=Idso_ac1*exp(arg_ac);

    Vcac=Vcoac+Mu*(Vdso-Vds);
    Vbac=Vbc+Vcac;
    Vaac=Vbac-Vba;
    //$debug("Vcac,Vbac,Vaac=%e %e %e",Vcac,Vbac,Vaac);
    if (Vcoac >= Vgoac)
    begin
        gmoff_ac= Gmmaxac_N;
    end else
    begin
        if (Vcoac <= Vtoac_N)
        begin
            gmoff_ac= 0.0;
        end else
        begin
            gmoff_ac= Gmmaxac_N/2*(cos(pi*(Vcoac-Vgoac)/(Vtoac_N-Vgoac))+1);
        end
    end
    svb_ac=Deltgmac_N*Vbc/sqrt(Alpha*Alpha+Vbc*Vbc);
    b_ac=svb_ac*Vba/(Deltgmac_N*(sqrt(Alpha*Alpha+(Vbac-Vcac)*(Vbac-Vcac))-Alpha)-gmoff_ac);
    a_ac=(Deltgmac_N*(sqrt(Alpha*Alpha+(Vbac-Vcac)*(Vbac-Vcac))-Alpha)-gmoff_ac)/(pow(Vba,b_ac));
    //$debug("a_ac,b_ac,svb_ac=%e %e %e",a_ac,b_ac,svb_ac);

    if(Vgs_ac > Vbac)
    begin
        Idsvtemp=Deltgmac_N*(0.5*((Vbac-Vcac)*sqrt(Alpha*Alpha+(Vbac-Vcac)*(Vbac-Vcac))+Alpha*Alpha*ln(((Vbac-Vcac)+sqrt(Alpha*Alpha+(Vbac-Vcac)*(Vbac-Vcac)))/Alpha))-Alpha*(Vbac-Vcac));
        Idsv_All_ac= a_ac/(b_ac+1)*(pow((Vgs_ac-Vaac),(b_ac+1))-pow(Vba,(b_ac+1)))+gmoff_ac*(Vgs_ac-Vbac)+Idsvtemp;
        //$debug("1 Idsv_All_ac = %e",Idsv_All_ac);
    end else
    begin
        if(Vgs_ac <= Vcac)
        begin
            Idsv_All_ac=0.0;
        end else
        begin
            Idsv_All_ac= Deltgmac_N*(0.5*((Vgs_ac-Vcac)*sqrt(Alpha*Alpha+(Vgs_ac-Vcac)*(Vgs_ac-Vcac))+Alpha*Alpha*ln(((Vgs_ac-Vcac)+sqrt(Alpha*Alpha+(Vgs_ac-Vcac)*(Vgs_ac-Vcac)))/Alpha))-Alpha*(Vgs_ac-Vcac)) ;
            //$debug("2 Idsv_All_ac = %e",Idsv_All_ac);
        end
    end
    I_ds_ac=(Idso_ac-Idsv_All_ac)*(1+Kapaac*Vds)*tanh(3*Vds/Vsat);
    if(I_ds_ac<0)
    begin
        I_ds_ac=0;
        //$write("I_ds_ac<0 for Vds=%e and Vgs=%e\n",V(d,s),V(g,s));
    end
    //$debug("Ids0,Ids0_ac = %e %e",Idso,Idso_ac);
    Pdiss_ac=I_ds_ac*Vds;
    Ids_ac=I_ds_ac/(1+Pdiss_ac/Peffac_N);
    //$debug("Ids,Ids_ac = %e %e",Ids,Ids_ac);
    if (Vds>Vdsm && Kdb_N!= 0)
    begin
        Idbp= sqrt(Gdbm_N/Kdb_N)*atan((Vds-Vdsm)*sqrt(Kdb_N*Gdbm_N))+Gdbm_N*Vdsm;
    end else
    begin
        if (Vds<-Vdsm && Kdb_N!= 0)
        begin
            Idbp=sqrt(Gdbm_N/Kdb_N)*atan((Vds-Vdsm)*sqrt(Kdb_N*Gdbm_N))-Gdbm_N*Vdsm;
        end else
        begin
            Idbp=Gdbm_N*Vds;
        end
    end
    Idb=Ids_ac-Ids+Idbp;
    //$debug("Ids_ac,Ids = %e %e",Ids_ac,Ids);
    Igs=Is_N*(exp_soft(chargeconst*V(gi,si)/(N*boltzmannconst*(Temp_NK)))-1)+Is_N2*(exp_soft(V(gi,si)/N2)-1)*V(di,si);
    if (-V(gi,di)>Vbr)
    begin
        Igd=-Kbk_N*(1-Ids/Idsoc_N)*pow(-V(gi,di)-Vbr+rev1,Nbr)+rev2;
    end else
    begin
        Igd=0;
    end
    //Idsdelay=absdelay(Ids,Tau_lag);
    //Idbdelay=absdelay(Idb,Tau_lag);

    Vgc=V(gi,sii);
    Vgy=V(gi,dii);

    f1=0.5*(1+tanh(3/Deltds*(Vgc-Vgy)));
    f2=0.5*(1-tanh(3/Deltds*(Vgc-Vgy)));

    Vj=0.5*(2*Vgc-(Vgc-Vgy)+sqrt((Vgc-Vgy)*(Vgc-Vgy)+Deltds*Deltds));
    Vo=sqrt((Vgc-Vgy)*(Vgc-Vgy)+Deltds*Deltds);
    gV=Vj-Vinfl_N+Deltgs/3*ln(cosh(3/Deltgs*(Vj-Vinfl_N)));
    qg=((C11o_N-C11th_N)/2*gV+C11th_N*(Vj-Vinfl_N))*(1+Lambda*(Vo-Vdso))-C12sat_N*Vo;
    qgy=(qg-Cgdsat_N*Vgc)*f2+Cgdsat_N*Vgy*f1;
    qgc=(qg-Cgdsat_N*Vgy)*f1+Cgdsat_N*Vgc*f2;

    Xb=(Nvg1*exp(V(gi,si)*Nvg2))*(Nvd1*V(di,si)+Nvd2)*(UGW_nor*NOF)/2.0/75.0;

    if(Vds2>0)
    begin
        I(di,si) <+ Idsdelay;
        I(ds) <+ Idbdelay;
        I(di,si) <+ (V(ds)/Rdb_N+Idbdelay);
    end else
    begin
        I(di,si) <+ -Idsdelay;
        I(ds) <+ -Idbdelay;
        I(di,si) <+ (V(ds)/Rdb_N-Idbdelay);
    end

    I(gi,si) <+ Igs;
    I(gi,di) <+ Igd;
    I(g,gi) <+ V(g,gi)/Rg_N; //g==n8 gi=gg si=ss di=dd
    I(di,dii) <+ V(di,dii)/Rid_N; //dii==n6
    I(si,sii) <+ V(si,sii)/Ris_N; //sii==n5
    I(d,di) <+ V(d,di)/Rd_N; //d==n1
    I(s,si) <+ V(s,si)/Rs_N; //s==n0
    I(ds) <+ V(ds)/Rdb_N; //ds==ds
    I(di,dsi) <+ V(di,dsi)/Rdb_N/RSCALE; //ds==ds
    I(dsi,si) <+ ddt(Cbs_N/RSCALE*V(dsi,si));
    I(di,si) <+ ddt(Cdso_N*V(di,si));
    I(ds) <+ ddt(Cbs_N*V(ds));
    I(gi,sii) <+ ddt(qgc);
    I(gi,dii) <+ ddt(qgy);

    //NOISE
    I(g,gi) <+ white_noise(4.0 * boltzmannconst * Temp_NK*BW/Rg_N);
    I(di,dii) <+ white_noise(4.0 * boltzmannconst * Temp_NK*BW/Rid_N);
    I(si,sii) <+ white_noise(4.0 * boltzmannconst * Temp_NK*BW/Ris_N);
    I(d,di) <+ white_noise(4.0 * boltzmannconst * Temp_NK*BW/Rd_N);
    I(s,si) <+ white_noise(4.0 * boltzmannconst * Temp_NK*BW/Rs_N);
    I(di,dsi) <+ white_noise(4.0 * boltzmannconst * Temp_NK*BW/Rdb_N/RSCALE);
    I(di,si) <+ white_noise(4.0 * boltzmannconst * Temp_NK*BW*Xb);
    I(gi,di) <+ white_noise(4.0 * boltzmannconst * Temp_NK*BW*Xb1);

    end

endmodule
