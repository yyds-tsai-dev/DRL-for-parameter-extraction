//EEHEMT14 implementation in Verilog A by Samuel Mertens - Agilent
// new table_model

`include "disciplines.vams"
`include "constants.vams"
// `include "compact.vams"

`define max_arg 40

module eehemt114_va_model (d, g, s);

	// %%DEVICE_CLASS=FET(NFET)%%

    parameter real UGW_N = 1.0; // ineffective
    parameter real NGF_N = 1.0; // ineffective
	parameter real Temp_N = 25.0; // input Temp
	parameter real on_off = 0; // noise on off

	parameter real UGW = 100; // input UGW
    parameter real NOF = 4; // input NOF

	parameter real Rgtc=0;
	parameter real Rdtc=0;
	parameter real Rstc=0;
	real Rg=2.527201993; // scalable eq
	parameter real Ris=0.3;
	parameter real Rid=0.001;
	parameter real Rs=2;
	parameter real Rd=1;
	parameter real Rdb=5e7;
	parameter real Cbs=1e-15;
	real Cdso=4.82899E-14; // scalable eq
	real Ugw=75;
	real Ngf=2;
	parameter real Tnom=25.0;
	parameter real Vsat=0.57;
	real Vto=0.234625804; // scalable eq
	real Vtso=0.358207805;
	parameter real Vtotc=0;
	parameter real Vch=1.4;
	parameter real Vdso=3.5;
	parameter real Gamma=0.0095;
	parameter real Gammatc=0;
	real Vgo=0.618318978;
	real Gmmax=0.159877013; // scalable eq
	parameter real Gmmaxtc=0;
	real Kapa=0.11372558; // scalable eq
	parameter real Vco=0.75;
	parameter real Mu=7.86e-6;
	parameter real Vbc=0.95;
	parameter real Vba=4.8;
	parameter real Deltgm=0.252;
	parameter real Alpha=0.01;
	real Peff=0.617453448; // scalable eq
	parameter real Tau_lag=1.5e-12;
	real Vtoac=0.206665003;
	parameter real Vtoactc=0;
	parameter real Gammaac=0.0126;
	parameter real Gammaactc=0;
	parameter real Vgoac=0.625;
	parameter real Vtsoac=0.3429;
	real Gmmaxac=0.145066993; // scalable eq
	parameter real Gmmaxactc=0;
	parameter real Vcoac=0.63;
	parameter real Deltgmac=0.32;
	parameter real Kapaac=0.045;
	parameter real Peffac=10;
	parameter real Kdb=50;
	parameter real Vdsm=1;
	parameter real Gdbm=1e-5;
	real Is=5.71752E-13;
	parameter real Xti=3;
	real N=1.697394727;
	parameter real Is2=5e-14;
	parameter real N2=0.037;
	real Kbk=2.64004E-14;
	parameter real Vbr=0;
	parameter real Idsoc=0.393;
	parameter real Nbr=8.6;
	parameter real rev1=0.03;
	parameter real rev2=1.1e-7;
	parameter real Xb1=0;
	parameter real Deltds=0.693;
	parameter real Deltgs=0.378;
	parameter real Vinfl=0.398;
	parameter real Vinfltc=0;
	parameter real C11o=347e-15;
	parameter real C11th=70e-15;
	real C12sat=2.98581E-14; // scalable eq
	real Cgdsat=2.80045E-14; // scalable eq
	parameter real Lambda=0.12;
	parameter real Nvg1=650e-9;
	parameter real Nvg2=9.6;
	parameter real Nvd1=75.5;
	parameter real Nvd2=183.6;
	parameter real UGW_nor=0;
	real Lg=3.04569E-11;// scalable eq
	real Ld=2.72143E-11;// scalable eq
	parameter real Ls=2.773e-12;
	real Cgp=5.87502E-14;// scalable eq
	parameter real Cdp=12e-15;

	// parameter real Vg_mean=6.000000e-01;
	// parameter real Vg_std =0.353555;
	// parameter real Vd_mean=2.750000;
	// parameter real Vd_std =1.53;
	// parameter real Inverse_weight=0.357248;
	// parameter real Inverse_bias=0.707048;

    // real X[1:6];   // Array to store X11 to X16 values (Layer 1)
    // real X2[1:5];  // Array to store X21 to X25 values (Layer 2)
    // real X3[1:4];  // Array to store X31 to X34 values (Layer 3)
    // real Alpha1;   // To store the final Alpha1 value
    integer i,j;

        inout d, g, s;
    electrical dm, gm, sm, d, g, s, di, gi, si, dii, sii, ds, dsi;

	real Rg_N,Temp_NK,Tnom_K,sfg,sf,Ris_N,Rid_N,Rs_N,Rd_N,Rdb_N;
	real Cdso_N,Cbs_N,Vto_N,Gamma_N,Vtso_N,Gmmax_N,Deltgm_N,Peff_N;
	real Vtoac_N,Gammaac_N,Vtsoac_N,Gmmaxac_N,Deltgmac_N,Peffac_N;
	real Kdb_N,Gdbm_N,Kbk_N,Idsoc_N,C11o_N,C11th_N,C12sat_N,Cgdsat_N,Vinfl_N;
	real Bandwidth,BW;
	real Vds2,Vgs2,Vds,Vgs,Vgs1,Vts,Vt,Vg,Vx,Idso1,arg,Idso,gmo1;
	real I_ds,Vc,Vb,Va,Idsv_All,Idsvtemp,gmoff,a,b,svb,Pdiss;
	real Vgs_ac,Vts_ac,Vt_ac,Vg_ac,Vx_ac,Idso_ac1,gmo_ac1,arg_ac,Idso_ac;
	real Vcac,Vbac,Vaac,gmoff_ac,a_ac,b_ac,svb_ac,Idsv_All_ac;
	real I_ds_ac,Pdiss_ac,Ids_ac,Idbp,Idb;
	(*retrieve*) real Igs,Igd,Ids;
	real Is_N,Is_N2,Idsdelay,Idbdelay;
	real f1,f2,Vj,Vo,Vgc,Vgy,gV,qg,qgc,qgy;
	real chargeconst,boltzmannconst;
	real tempsqrt,RSCALE,Xb;
	real pi;
	real Total,IdsANN,Ids1;
	real Vggg,Id,Vd,predict;

	analog function real  exp_soft;
        input x;
        real  x;
        begin
           if (x < `max_arg)
               exp_soft = exp(x);
            else
               exp_soft = (x + 1 - `max_arg) * exp(`max_arg);
        end
    endfunction

       //V(g,s),V(d,s),Ids1
       //input Vgs2,Vds2,Ids;
    //    real Vgs2,Vds2,Ids;

       //real X11,X12,X13,X14,X15,X21,X22,X23,X24,X31,X32,X33,X16,X25,X34;

       //begin

    analog begin
	chargeconst = 1.602192e-019;
	boltzmannconst= 1.380623e-023;
	RSCALE=1e6;
	Temp_NK=Temp_N+273.15;
	Tnom_K=Tnom+273.15;
	sf=UGW*NOF/(Ugw*Ngf);
	sfg=Ugw*NOF/(UGW*Ngf);
	Bandwidth=1.0;
	BW=Bandwidth*on_off;
	pi=3.14159265359;
	Total=UGW*NOF;
	Rg=(24178.914*pow(UGW,-2.21)+1.5-(0.1443*ln(NOF)-0.1))*0.2454*exp(0.005*Temp_NK);
	Rg_N=Rg*(1+Rgtc*(Temp_NK-Tnom_K))/sfg;
	Rd_N=Rd*(1+Rdtc*(Temp_NK-Tnom_K))/sf;
	Rs_N=Rs*(1+Rstc*(Temp_NK-Tnom_K))/sf;
	Ris_N=Ris/sf;
	Rid_N=Rid/sf;
    Rdb_N=Rdb/sf/RSCALE;
	Lg=46.54*exp(-0.106*NOF)*1e-12;
	Ld=(0.2711*UGW+0.1043)*1e-12;
	Cgp=(5.5457*NOF+6.414)*exp(0.0006*NOF*UGW+0.0048*UGW)*1e-15;
	if (NOF<4) begin
        Cdso = 1.0289*pow(UGW,0.7639)*1e-15;
    end else begin
		Cdso = 2.5413*pow(UGW,0.6394)*1e-15;
    end
    Cdso_N=Cdso*sf;
	Cbs_N=Cbs*sf*RSCALE;
	Gamma_N=Gamma*pow((Temp_NK/Tnom_K),Gammatc);
	Vtso=( 0.348 )*( (3.6561)+(-1.705)*ln((3.0515)*Temp_NK)+(3.3413)*pow(Temp_NK,0.17371));
	Vtso_N=Vtso+Vtotc*(Temp_NK-Tnom_K);
	Gmmax=(0.1914*pow(UGW,-0.037))*33.5*pow(Temp_NK,-0.618);
	Gmmax_N=(Gmmax+Gmmaxtc*(Temp_NK-Tnom_K))*sf;
	Deltgm_N=Deltgm*sf;
	Peff=(8.8759*pow(Total,-0.437))*(-0.003325*Temp_NK + 1.945225);
	Peff_N=Peff*sf;
	Vtoac=0.208*(123.19*pow(Temp_NK,-0.846));
	Vtoac_N=Vtoac+Vtoactc*(Temp_NK-Tnom_K);
	Gammaac_N=Gammaac*pow((Temp_NK/Tnom_K),Gammaactc);
	Vtsoac_N=Vtsoac+Vtoactc*(Temp_NK-Tnom_K);
	if (UGW<=25) begin
        Gmmaxac= 0.1376*(-0.0014*Temp_NK+1.424);
    end else begin
		Gmmaxac= (0.1494*exp(-0.009*NOF))*(-0.0014*Temp_NK+1.424);
    end
	Gmmaxac_N=(Gmmaxac+Gmmaxactc*(Temp_NK-Tnom_K))*sf;
	Deltgmac_N=Deltgmac*sf;
	Peffac_N=Peffac*sf;
	Kdb_N=Kdb/sf;
	Gdbm_N=Gdbm*sf;
	N=1.152*exp(0.0013*Temp_NK);
	Is=4.421e-019*exp(0.0472*Temp_NK);
	Is_N=Is*sf*exp((Temp_NK/Tnom_K-1)*chargeconst*1.11/(boltzmannconst*N*(Temp_NK))+Xti/N*ln(Temp_NK/Tnom_K));
	Is_N2=Is2*sf*exp((Temp_NK/Tnom_K-1)*chargeconst*1.11/(boltzmannconst*N2*(Temp_NK))+Xti/N2*ln(Temp_NK/Tnom_K));
	Kbk=( 2.4e-14 )*( (36318.2873)*exp((-502.6176)*pow(Temp_NK,-0.64074))+(1.0223) );
	Kbk_N=Kbk*sf;
	Idsoc_N=Idsoc*sf;
	Vinfl_N=Vinfl+Vinfltc*(Temp_NK-Tnom_K);
	C11o_N=C11o*sf;
	C11th_N=C11th*sf;
	C12sat=(78.0584*pow(UGW,-0.1946)-2)*1e-15;
	C12sat_N=C12sat*sf;
	Cgdsat=136.53*pow(UGW,-0.344)*1e-15;
	Cgdsat_N=Cgdsat*sf;
	Vto=(0.227)*((1.3488)+(-0.074345)*ln((0.75477)*UGW))*(0.86)*((-9.1468)+(1.2971)*ln((1.2946)*Temp_NK)+(275.1544)*pow(Temp_NK,-0.81879));
	Vto_N=Vto+Vtotc*(Temp_NK-Tnom_K);
	Vds2=V(di,si);
	Vgs2=V(gi,si);
	Vgo=0.625*(1.2558*exp(-8e-4*Temp_NK));
	Kapa=0.027*pow(Total,0.24);
	//$debug("Vds2,Vgs2 = %e %e",Vds2,Vgs2);
	if(Vds2>=0)
	begin
		Vds=Vds2;
		Vgs1=Vgs2;
	end else
	begin
		Vds=-Vds2;
		Vgs1=Vgs2-Vds2;
	end
	Vts=(Vtso_N-Vch)/(1+Gamma_N*(Vdso-Vds))+Vch;
	if(Vgs1<Vts && Vtso_N>Vto_N)
	begin
		Vgs=Vts;
	end else
	begin
		Vgs=Vgs1;
	end

	Vt=(Vto_N-Vch)/(1+Gamma_N*(Vdso-Vds))+Vch;
	Vg=(Vgo-Vch)/(1+Gamma_N*(Vdso-Vds))+Vch;
	Vx=(Vgs-Vch)*(1+Gamma_N*(Vdso-Vds));

	if (Vgs >= Vg)
	begin
		Idso1=Gmmax_N*(Vx-(Vgo+Vto_N)/2+Vch);
		gmo1=Gmmax_N*(1+Gamma_N*(Vdso-Vds));
	end	else
	begin
		if (Vgs <= Vt)
		begin
			Idso1=0.0;
			gmo1=0.0;
		end else
		begin
			Idso1=Gmmax_N/2*(((Vto_N-Vgo)/pi)*sin(pi*(Vx-(Vgo-Vch))/(Vto_N-Vgo))+Vx-(Vto_N-Vch));
			gmo1=Gmmax_N/2*(1+Gamma_N*(Vdso-Vds))*(cos(pi*(Vx-(Vgo-Vch))/(Vto_N-Vgo))+1);
		end
	end
	if (Idso1!=0 && Vgs1<Vts && Vtso_N>Vto_N)
	begin
		arg=-(gmo1/Idso1)*(Vts-Vgs1);//might be discontinuous if Idso1==0
	end else
	begin
		arg=0.0;
	end
	Idso=Idso1*exp(arg);

	Vc=Vco+Mu*(Vdso-Vds);
	Vb=Vbc+Vc;
	Va=Vb-Vba;
	if (Vco >= Vgo)
	begin
		gmoff=Gmmax_N;
	end else
	begin
		if (Vco <= Vto_N)
		begin
			gmoff=0.0;
		end else
		begin
			gmoff=0.5*Gmmax_N*(cos(pi*(Vco-Vgo)/(Vto_N-Vgo))+1);
		end
	end
	svb=Deltgm_N*Vbc/sqrt(Alpha*Alpha+Vbc*Vbc);
	b=svb*Vba/(Deltgm_N*(sqrt(Alpha*Alpha+(Vb-Vc)*(Vb-Vc))-Alpha)-gmoff);
	a=(Deltgm_N*(sqrt(Alpha*Alpha+(Vb-Vc)*(Vb-Vc))-Alpha)-gmoff)/(pow(Vba,b));
	//$debug("Vc,Vb,Va=%e %e %e",Vc,Vb,Va);
	//$debug("a,b,svb=%e %e %e",a,b,svb);
	if(Vgs > Vb)
	begin
		tempsqrt=sqrt(Alpha*Alpha+(Vb-Vc)*(Vb-Vc));
		Idsvtemp=Deltgm_N*(0.5*((Vb-Vc)*tempsqrt+Alpha*Alpha*ln(((Vb-Vc)+tempsqrt)/Alpha))-Alpha*(Vb-Vc));
		Idsv_All=a/(b+1)*((pow((Vgs-Va),(b+1.0))-pow(Vba,(b+1.0))))+gmoff*(Vgs-Vb)+Idsvtemp;
		//$debug("1 Idsv_All = %e %e %e",Idsv_All,(Vgs-Va),Vba);
	end else
	begin
		if(Vgs <= Vc)
		begin
			Idsv_All=0.0;
			//$debug("3 Idsv_All");
		end
		else begin
			//Idsv_All=Deltgm_N*(0.5*((Vgs-Vc)*sqrt(Alpha*Alpha+(Vgs-Vc)*(Vgs-Vc))+Alpha*Alpha*ln(((Vgs-Vc)+sqrt(Alpha*Alpha+(Vgs-Vc)*(Vgs-Vc)))/Alpha))-Alpha*(Vgs-Vc));
			tempsqrt=sqrt(Alpha*Alpha+(Vgs-Vc)*(Vgs-Vc));
			Idsv_All=Deltgm_N*(0.5*((Vgs-Vc)*tempsqrt+Alpha*Alpha*ln(((Vgs-Vc)+tempsqrt)/Alpha))-Alpha*(Vgs-Vc));
			//$debug("2 Idsv_All = %e %e %e %e\n",Idsv_All,(Vgs-Vc),tempsqrt,Deltgm_N);
		end
	end
	I_ds=(Idso-Idsv_All)*(1+Kapa*Vds)*tanh(3*Vds/Vsat);
	if(I_ds<0)
	begin
		I_ds=0;
		//$write("I_ds<0 for Vds=%e and Vgs=%e\n",V(d,s),V(g,s));
	end;
	//$debug("Idso,Idsv_All = %e %e",Idso,Idsv_All);
	Pdiss=I_ds*Vds;
        //IdsANN=Alpha1(Vgs2,Vds2,Ids);
        // Ids1=I_ds/(1+Pdiss/Peff_N);
		Ids=I_ds/(1+Pdiss/Peff_N);
		// 	    Vggg=(V(g,s)-Vg_mean)/Vg_std;
        // Id=0.005657*Ids1*2500 -1.066087;
        // Vd=(V(d,s)-Vd_mean)/Vd_std;

		// For loop to compute X11 to X16 (Layer 1)
		// for (i = 1; i <= 6; i = i + 1) begin
		// 	X[i] = $table_model(1, i, 1, "sample1.dat") * Vggg
		// 		+ $table_model(1, i, 2, "sample1.dat") * Id
		// 		+ $table_model(1, i, 3, "sample1.dat") * Vd
		// 		+ $table_model(1, i, 1, "sample2.dat");
		// 	X[i] = max(0, X[i]);
		// end

			// For loop to compute X21 to X25 (Layer 2)
		// for (i = 1; i <= 5; i = i + 1) begin
        //                      X2[i] = 0;
		//     for (j = 1; j <= 6; j = j + 1) begin
		// 		X2[i] = X2[i] + $table_model(2, i, j, "sample1.dat") * X[j];end
		// 	X2[i] = X2[i] + $table_model(2, i, 1, "sample2.dat");
		// 	X2[i] = max(0, X2[i]);
		// end

		// For loop to compute X31 to X34 (Layer 3)
		// for (i = 1; i <= 4; i = i + 1) begin
        //                         X3[i] = 0;
		//     for (j = 1; j <= 5; j = j + 1) begin
		// 		X3[i] = X3[i] +  $table_model(3, i, j, "sample1.dat") * X2[j];end
		// 	X3[i] = X3[i] + $table_model(3, i, 1, "sample2.dat");
		// 	X3[i] = max(0, X3[i]);
		// end

		// Compute Alpha1 using results from Layer 3
		// Alpha1 = ( $table_model(4, 1, 1, "sample1.dat") * X3[1]
		// 		+ $table_model(4, 1, 2, "sample1.dat") * X3[2]
		// 		+ $table_model(4, 1, 3, "sample1.dat") * X3[3]
		// 		+ $table_model(4, 1, 4, "sample1.dat") * X3[4]
		// 		+ $table_model(4, 1, 1, "sample2.dat") )
		// 		* Inverse_weight + Inverse_bias;
	//$debug("Alpha1 = %e ",X[1]);
        // Ids=Ids1*Alpha1;
	//$debug("Ids,I_ds,Pdiss = %e %e %e",Ids,I_ds,Pdiss);
	Vts_ac=(Vtsoac_N-Vch)/(1+Gammaac_N*(Vdso-Vds))+Vch;
	if (Vgs1<Vts_ac && Vtsoac_N>Vtoac_N)
	begin
		Vgs_ac=Vts_ac;
	end else
	begin
		Vgs_ac=Vgs1;
	end
	//$debug("Vgs_ac,Vds,Vts_ac= %e %e %e",Vgs_ac,Vds,Vts_ac);
	Vt_ac=(Vtoac_N-Vch)/(1+Gammaac_N*(Vdso-Vds))+Vch;
	Vg_ac=(Vgoac-Vch)/(1+Gammaac_N*(Vdso-Vds))+Vch;
	Vx_ac=(Vgs_ac-Vch)*(1+Gammaac_N*(Vdso-Vds));

	if (Vgs_ac >= Vg_ac)
	begin
		Idso_ac1= Gmmaxac_N*(Vx_ac-(Vgoac+Vtoac_N)/2+Vch);
		gmo_ac1= Gmmaxac_N*(1+Gammaac_N*(Vdso-Vds));
	end else
	begin
		if (Vgs_ac <= Vt_ac)
		begin
			Idso_ac1= 0.0;
			gmo_ac1= 0.0;
		end else
		begin
			Idso_ac1= Gmmaxac_N/2*(((Vtoac_N-Vgoac)/pi)*sin(pi*(Vx_ac-(Vgoac-Vch))/(Vtoac_N-Vgoac))+Vx_ac-(Vtoac_N-Vch));
			gmo_ac1= Gmmaxac_N/2*(1+Gammaac_N*(Vdso-Vds))*(cos(pi*(Vx_ac-(Vgoac-Vch))/(Vtoac_N-Vgoac))+1);
		end
	end
	if (Idso_ac1!=0 && Vgs1<Vts_ac && Vtsoac_N>Vtoac_N)
	begin
		arg_ac=-(gmo_ac1/Idso_ac1)*(Vts_ac-Vgs1);
	end else
	begin
		arg_ac=0;
	end
	Idso_ac=Idso_ac1*exp(arg_ac);

	Vcac=Vcoac+Mu*(Vdso-Vds);
	Vbac=Vbc+Vcac;
	Vaac=Vbac-Vba;
	//$debug("Vcac,Vbac,Vaac=%e %e %e",Vcac,Vbac,Vaac);
	if (Vcoac >= Vgoac)
	begin
		gmoff_ac= Gmmaxac_N;
	end else
	begin
		if (Vcoac <= Vtoac_N)
		begin
			gmoff_ac= 0.0;
		end else
		begin
			gmoff_ac= Gmmaxac_N/2*(cos(pi*(Vcoac-Vgoac)/(Vtoac_N-Vgoac))+1);
		end
	end
	svb_ac=Deltgmac_N*Vbc/sqrt(Alpha*Alpha+Vbc*Vbc);
	b_ac=svb_ac*Vba/(Deltgmac_N*(sqrt(Alpha*Alpha+(Vbac-Vcac)*(Vbac-Vcac))-Alpha)-gmoff_ac);
	a_ac=(Deltgmac_N*(sqrt(Alpha*Alpha+(Vbac-Vcac)*(Vbac-Vcac))-Alpha)-gmoff_ac)/(pow(Vba,b_ac));
	//$debug("a_ac,b_ac,svb_ac=%e %e %e",a_ac,b_ac,svb_ac);

	if(Vgs_ac > Vbac)
	begin
		Idsvtemp=Deltgmac_N*(0.5*((Vbac-Vcac)*sqrt(Alpha*Alpha+(Vbac-Vcac)*(Vbac-Vcac))+Alpha*Alpha*ln(((Vbac-Vcac)+sqrt(Alpha*Alpha+(Vbac-Vcac)*(Vbac-Vcac)))/Alpha))-Alpha*(Vbac-Vcac));
		Idsv_All_ac= a_ac/(b_ac+1)*(pow((Vgs_ac-Vaac),(b_ac+1))-pow(Vba,(b_ac+1)))+gmoff_ac*(Vgs_ac-Vbac)+Idsvtemp;
		//$debug("1 Idsv_All_ac = %e",Idsv_All_ac);
	end else
	begin
		if(Vgs_ac <= Vcac)
		begin
			Idsv_All_ac=0.0;
		end else
		begin
			Idsv_All_ac= Deltgmac_N*(0.5*((Vgs_ac-Vcac)*sqrt(Alpha*Alpha+(Vgs_ac-Vcac)*(Vgs_ac-Vcac))+Alpha*Alpha*ln(((Vgs_ac-Vcac)+sqrt(Alpha*Alpha+(Vgs_ac-Vcac)*(Vgs_ac-Vcac)))/Alpha))-Alpha*(Vgs_ac-Vcac)) ;
			//$debug("2 Idsv_All_ac = %e",Idsv_All_ac);
		end
	end
	I_ds_ac=(Idso_ac-Idsv_All_ac)*(1+Kapaac*Vds)*tanh(3*Vds/Vsat);
	if(I_ds_ac<0)
	begin
		I_ds_ac=0;
		//$write("I_ds_ac<0 for Vds=%e and Vgs=%e\n",V(d,s),V(g,s));
	end
	//$debug("Ids0,Ids0_ac = %e %e",Idso,Idso_ac);
	Pdiss_ac=I_ds_ac*Vds;
	Ids_ac=I_ds_ac/(1+Pdiss_ac/Peffac_N);
	//$debug("Ids,Ids_ac = %e %e",Ids,Ids_ac);
	if (Vds>Vdsm && Kdb_N!= 0)
	begin
		Idbp= sqrt(Gdbm_N/Kdb_N)*atan((Vds-Vdsm)*sqrt(Kdb_N*Gdbm_N))+Gdbm_N*Vdsm;
	end else
	begin
		if (Vds<-Vdsm && Kdb_N!= 0)
		begin
			Idbp=sqrt(Gdbm_N/Kdb_N)*atan((Vds-Vdsm)*sqrt(Kdb_N*Gdbm_N))-Gdbm_N*Vdsm;
		end else
		begin
			Idbp=Gdbm_N*Vds;
		end
	end
	Idb=Ids_ac-Ids+Idbp;
	//$debug("Ids_ac,Ids = %e %e",Ids_ac,Ids);
	Igs=Is_N*(exp_soft(chargeconst*V(gi,si)/(N*boltzmannconst*(Temp_NK)))-1)+Is_N2*(exp_soft(V(gi,si)/N2)-1)*V(di,si);
	if (-V(gi,di)>Vbr)
	begin
		Igd=-Kbk_N*(1-Ids/Idsoc_N)*pow(-V(gi,di)-Vbr+rev1,Nbr)+rev2;
	end else
	begin
		Igd=0;
	end
	Idsdelay=absdelay(Ids,Tau_lag);
	Idbdelay=absdelay(Idb,Tau_lag);
	// Idsdelay=Ids;
	// Idbdelay=Idb;

	Vgc=V(gi,sii);
	Vgy=V(gi,dii);

	f1=0.5*(1+tanh(3/Deltds*(Vgc-Vgy)));
	f2=0.5*(1-tanh(3/Deltds*(Vgc-Vgy)));

	Vj=0.5*(2*Vgc-(Vgc-Vgy)+sqrt((Vgc-Vgy)*(Vgc-Vgy)+Deltds*Deltds));
	Vo=sqrt((Vgc-Vgy)*(Vgc-Vgy)+Deltds*Deltds);
	gV=Vj-Vinfl_N+Deltgs/3*ln(cosh(3/Deltgs*(Vj-Vinfl_N)));
	qg=((C11o_N-C11th_N)/2*gV+C11th_N*(Vj-Vinfl_N))*(1+Lambda*(Vo-Vdso))-C12sat_N*Vo;
	qgy=(qg-Cgdsat_N*Vgc)*f2+Cgdsat_N*Vgy*f1;
	qgc=(qg-Cgdsat_N*Vgy)*f1+Cgdsat_N*Vgc*f2;

	Xb=(Nvg1*exp(V(gi,si)*Nvg2))*(Nvd1*V(di,si)+Nvd2)*(UGW*NOF)/2.0/75.0;

	$debug("qgy ,qgc ,Ids ,width ,finger = %e %e %e %e %e",qgy,qgc,Ids,UGW,NOF);
        $debug("V(d,s) ,V(g,s)=%e %e", V(d,s),V(g,s));

	if(Vds2>0)
	begin
		I(di,si) <+ Idsdelay;
		I(ds) <+ Idbdelay;
		I(di,si) <+ (V(ds)/Rdb_N+Idbdelay);
	end else
	begin
		I(di,si) <+ -Idsdelay;
		I(ds) <+ -Idbdelay;
		I(di,si) <+ (V(ds)/Rdb_N-Idbdelay);
	end

	I(gi,si) <+ Igs;
	I(gi,di) <+ Igd;
	I(g,gi) <+ V(g,gi)/Rg_N; //g==n8 gi=gg si=ss di=dd
	I(di,dii) <+ V(di,dii)/Rid_N; //dii==n6
	I(si,sii) <+ V(si,sii)/Ris_N; //sii==n5
	I(d,di) <+ V(d,di)/Rd_N; //d==n1
	I(s,si) <+ V(s,si)/Rs_N; //s==n0
	I(ds) <+ V(ds)/Rdb_N; //ds==ds
	I(di,dsi) <+ V(di,dsi)/Rdb_N/RSCALE; //ds==ds
	I(dsi,si) <+ ddt(Cbs_N/RSCALE*V(dsi,si));
	I(di,si) <+ ddt(Cdso_N*V(di,si));
	I(ds) <+ ddt(Cbs_N*V(ds));
	I(gi,sii) <+ ddt(qgc);
	I(gi,dii) <+ ddt(qgy);
	V(gm,g) <+ Lg*ddt(I(gm,g));
	I(g) <+ Cgp*ddt(V(g));
	V(dm,d) <+ Ld*ddt(I(dm,d));
	I(d) <+ Cdp*ddt(V(d));
	V(s,sm) <+ Ls*ddt(I(s,sm));

	//NOISE
	I(g,gi) <+ white_noise(4.0 * boltzmannconst * Temp_NK*BW/Rg_N);
    I(di,dii) <+ white_noise(4.0 * boltzmannconst * Temp_NK*BW/Rid_N);
	I(si,sii) <+ white_noise(4.0 * boltzmannconst * Temp_NK*BW/Ris_N);
    I(d,di) <+ white_noise(4.0 * boltzmannconst * Temp_NK*BW/Rd_N);
	I(s,si) <+ white_noise(4.0 * boltzmannconst * Temp_NK*BW/Rs_N);
	I(di,dsi) <+ white_noise(4.0 * boltzmannconst * Temp_NK*BW/Rdb_N/RSCALE);
	I(di,si) <+ white_noise(4.0 * boltzmannconst * Temp_NK*BW*Xb);
    I(gi,di) <+ white_noise(4.0 * boltzmannconst * Temp_NK*BW*Xb1);

	end

endmodule
